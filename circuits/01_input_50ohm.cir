* Practice model: 1 V, 10 ns pulse into a 50 ohm termination

Vin input 0 PULSE(0 1 1n 1p 1p 10n 30n)
Rterm input 0 50

.control
tran 0.01n 15n
let input_current = -i(Vin)
meas tran peak_current MAX input_current FROM=1n TO=11n
meas tran input_charge INTEG input_current FROM=1n TO=11.001n
.endc

.end
